* Output Impedance - Two Stage Op-Amp

.lib /home/wshh/.volare/volare/sky130/versions/0fe599b2afb6708d281543108caf8310912f54af/sky130A/libs.tech/ngspice/sky130.lib.spice tt
.option scale=1e-6

VDD vdd GND 1.8
VSS vss GND 0
VCM vcm GND 0.9

* Op-amp with both inputs at VCM
x1 vout vdd vcm vcm vss opamp_2stage

* AC test current at output
Itest vout GND AC 1

.subckt opamp_2stage VOUT VDD VIN_N VIN_P VSS
* Stage 1: Differential pair + current mirror load
XM3 VDD net1 net1 VDD sky130_fd_pr__pfet_01v8 L=0.5 W=5 nf=1 m=1
XM4 vi net1 VDD VDD sky130_fd_pr__pfet_01v8 L=0.5 W=5 nf=1 m=1
XM1 net1 VIN_P net2 GND sky130_fd_pr__nfet_01v8 L=0.5 W=5 nf=1 m=1
XM2 vi VIN_N net2 GND sky130_fd_pr__nfet_01v8 L=0.5 W=5 nf=1 m=1
VB2 vbias GND 0.7
XM9 net2 vbias VSS GND sky130_fd_pr__nfet_01v8 L=0.5 W=5 nf=1 m=1

* Stage 2: Common source output stage
XM5 VOUT vi VDD VDD sky130_fd_pr__pfet_01v8 L=0.5 W=5 nf=1 m=1
XM6 VOUT vbias VSS GND sky130_fd_pr__nfet_01v8 L=0.5 W=5 nf=1 m=1

* Miller compensation
Rz vi rz_out 5k
Cc rz_out VOUT 2p
.ends

.GLOBAL GND

.control
op
ac dec 10 1 1G
let zout = v(vout)/1
plot mag(zout) xlog title 'Output Impedance vs Frequency'
print mag(zout)[0]
echo "Target: < 1k ohm"
.endc

.end
