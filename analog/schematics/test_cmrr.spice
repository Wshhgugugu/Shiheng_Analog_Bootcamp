* CMRR Measurement Testbench

.lib /home/wshh/.volare/volare/sky130/versions/0fe599b2afb6708d281543108caf8310912f54af/sky130A/libs.tech/ngspice/sky130.lib.spice tt
.option scale=1e-6

* Power supplies
VDD vdd GND 1.8
VSS vss GND 0

* Common-mode input (will be swept)
VCM vcm GND 0.9

* Connect both inputs to same voltage (common-mode test)
x1 vout vdd vcm vcm vss opamp_single_stage

* Op-amp subcircuit
.subckt opamp_single_stage VOUT VDD VIN_N VIN_P VSS
XM3 VDD net1 net1 VDD sky130_fd_pr__pfet_01v8 L=0.5 W=5 nf=1 m=1
XM4 VOUT net1 VDD VDD sky130_fd_pr__pfet_01v8 L=0.5 W=5 nf=1 m=1
VB2 net3 GND 0.7
XM9 net2 net3 VSS GND sky130_fd_pr__nfet_01v8 L=0.5 W=5 nf=1 m=1
XM1 net1 VIN_P net2 GND sky130_fd_pr__nfet_01v8 L=0.5 W=5 nf=1 m=1
XM2 VOUT VIN_N net2 GND sky130_fd_pr__nfet_01v8 L=0.5 W=5 nf=1 m=1
.ends

.GLOBAL GND

.control
* Sweep common-mode voltage
dc VCM 0.5 1.3 0.01
plot v(vout) vs v(vcm) title 'Common-mode Response'

* Measure common-mode gain at VCM=0.9V
meas dc acm DERIV v(vout) AT=0.9
print acm

echo "=============================="
echo "Differential gain Ad = 70 V/V"
echo "Common-mode gain Acm = above value"
echo "CMRR = 20*log10(70/|Acm|) dB"
echo "=============================="
.endc

.end
