* COMPLETE TEST - Three Stage Op-Amp

.lib /home/wshh/.volare/volare/sky130/versions/0fe599b2afb6708d281543108caf8310912f54af/sky130A/libs.tech/ngspice/sky130.lib.spice tt
.option scale=1e-6

.subckt opamp_3stage VOUT VDD VIN_N VIN_P VSS
XM3 VDD net1 net1 VDD sky130_fd_pr__pfet_01v8 L=0.5 W=5 nf=1 m=1
XM4 vi net1 VDD VDD sky130_fd_pr__pfet_01v8 L=0.5 W=5 nf=1 m=1
XM1 net1 VIN_P net2 GND sky130_fd_pr__nfet_01v8 L=0.5 W=5 nf=1 m=1
XM2 vi VIN_N net2 GND sky130_fd_pr__nfet_01v8 L=0.5 W=5 nf=1 m=1
VB2 vbias GND 0.7
XM9 net2 vbias VSS GND sky130_fd_pr__nfet_01v8 L=0.5 W=5 nf=1 m=1
XM5 vout_s2 vi VDD VDD sky130_fd_pr__pfet_01v8 L=0.5 W=5 nf=1 m=1
XM6 vout_s2 vbias VSS GND sky130_fd_pr__nfet_01v8 L=0.5 W=5 nf=1 m=1
Rz vi rz_out 5k
Cc rz_out vout_s2 2p
XM7 VOUT vout_s2 VDD VDD sky130_fd_pr__pfet_01v8 L=0.5 W=10 nf=1 m=1
XM8 VOUT vout_s2 VSS GND sky130_fd_pr__nfet_01v8 L=0.5 W=10 nf=1 m=1
.ends

.GLOBAL GND

*===========================================
* TEST 1: DC GAIN & POWER
*===========================================
VDD1 vdd1 GND 1.8
VSS1 vss1 GND 0
VCM1 vcm1 GND 0.9
VDIFF1 vdiff1 vcm1 0
R1 vin_n1 vcm1 1M
R2 vin_p1 vdiff1 1M
x1 vout1 vdd1 vin_n1 vin_p1 vss1 opamp_3stage

*===========================================
* TEST 2: CMRR
*===========================================
VDD2 vdd2 GND 1.8
VSS2 vss2 GND 0
VCM2 vcm2 GND 0.9
x2 vout2 vdd2 vcm2 vcm2 vss2 opamp_3stage

*===========================================
* TEST 3: OUTPUT IMPEDANCE
*===========================================
VDD3 vdd3 GND 1.8
VSS3 vss3 GND 0
VCM3 vcm3 GND 0.9
x3 vout3 vdd3 vcm3 vcm3 vss3 opamp_3stage
Itest vout3 GND AC 1

.control
echo "=============================================="
echo "  THREE STAGE OP-AMP - COMPLETE TEST SUITE"
echo "=============================================="
echo ""

* TEST 1: DC GAIN
echo ">>> TEST 1: DIFFERENTIAL GAIN <<<"
dc VDIFF1 -0.01 0.01 0.0001
meas dc vout_max MAX v(vout1)
meas dc vout_min MIN v(vout1)
let gain = (vout_max - vout_min) / 0.02
let gain_db = 20 * log10(abs(gain))
echo "Differential Gain:"
print gain gain_db
echo "Target: >= 20 dB"
echo ""

* TEST 2: POWER
echo ">>> TEST 2: POWER CONSUMPTION <<<"
op
let power_uw = abs(i(VDD1)) * 1.8 * 1e6
echo "Power:"
print i(VDD1) power_uw
echo "Target: < 5 mW (5000 uW)"
echo ""

* TEST 3: CMRR
echo ">>> TEST 3: CMRR <<<"
dc VCM2 0.5 1.3 0.01
meas dc vout_cm_max MAX v(vout2)
meas dc vout_cm_min MIN v(vout2)
let acm = (vout_cm_max - vout_cm_min) / 0.8
let cmrr = gain / abs(acm)
let cmrr_db = 20 * log10(abs(cmrr))
echo "Common-mode Gain (Acm):"
print acm
echo "CMRR:"
print cmrr cmrr_db
echo "Target: >= 40 dB"
echo ""

* TEST 4: OUTPUT IMPEDANCE
echo ">>> TEST 4: OUTPUT IMPEDANCE <<<"
ac dec 10 1 1G
let zout = mag(v(vout3))
echo "Output Impedance at 1Hz:"
print zout[0]
echo "Target: < 1k ohm"
echo ""

* TEST 5: INPUT IMPEDANCE
echo ">>> TEST 5: INPUT IMPEDANCE <<<"
echo "Input is MOSFET gate -> Zin > 10^12 ohm"
echo "Target: > 1M ohm -> PASS"
echo ""

echo "=============================================="
echo "  TEST COMPLETE - CHECK RESULTS ABOVE"
echo "=============================================="

* Plot DC transfer curve
dc VDIFF1 -0.01 0.01 0.0001
plot v(vout1) title 'DC Transfer Curve (Gain Test)'

.endc

.end
