* Output Impedance - Three Stage Op-Amp

.lib /home/wshh/.volare/volare/sky130/versions/0fe599b2afb6708d281543108caf8310912f54af/sky130A/libs.tech/ngspice/sky130.lib.spice tt
.option scale=1e-6

VDD vdd GND 1.8
VSS vss GND 0
VCM vcm GND 0.9

x1 vout vdd vcm vcm vss opamp_3stage

Itest vout GND AC 1

.subckt opamp_3stage VOUT VDD VIN_N VIN_P VSS
* Stage 1
XM3 VDD net1 net1 VDD sky130_fd_pr__pfet_01v8 L=0.5 W=5 nf=1 m=1
XM4 vi net1 VDD VDD sky130_fd_pr__pfet_01v8 L=0.5 W=5 nf=1 m=1
XM1 net1 VIN_P net2 GND sky130_fd_pr__nfet_01v8 L=0.5 W=5 nf=1 m=1
XM2 vi VIN_N net2 GND sky130_fd_pr__nfet_01v8 L=0.5 W=5 nf=1 m=1
VB2 vbias GND 0.7
XM9 net2 vbias VSS GND sky130_fd_pr__nfet_01v8 L=0.5 W=5 nf=1 m=1

* Stage 2
XM5 vout_s2 vi VDD VDD sky130_fd_pr__pfet_01v8 L=0.5 W=5 nf=1 m=1
XM6 vout_s2 vbias VSS GND sky130_fd_pr__nfet_01v8 L=0.5 W=5 nf=1 m=1

* Miller compensation
Rz vi rz_out 5k
Cc rz_out vout_s2 2p

* Stage 3: Push-pull output
XM7 VOUT vout_s2 VDD VDD sky130_fd_pr__pfet_01v8 L=0.5 W=10 nf=1 m=1
XM8 VOUT vout_s2 VSS GND sky130_fd_pr__nfet_01v8 L=0.5 W=10 nf=1 m=1
.ends

.GLOBAL GND

.control
op
ac dec 10 1 1G
let zout = v(vout)/1
plot mag(zout) xlog title 'Output Impedance - 3 Stage'
print mag(zout)[0]
echo "Target: < 1k ohm"
.endc

.end
