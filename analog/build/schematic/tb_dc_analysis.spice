** sch_path: /home/wshh/Shiheng_Analog_Bootcamp/analog/build/schematic/tb_dc_analysis.sch
**.subckt tb_dc_analysis
VSS net1 GND 0
VDD net4 GND 1.8
VCM net3 GND 0.9
VDIFF net2 net3 0
x1 net5 net4 net3 net2 net1 opamp_single_stage
**** begin user architecture code

.lib /home/wshh/.volare/volare/sky130/versions/0fe599b2afb6708d281543108caf8310912f54af/sky130A/libs.tech/ngspice/sky130.lib.spice tt
.control
save all
dc VDIFF -0.01 0.01 0.0001
plot v(vout)
plot deriv(v(vout))
.endc

**** end user architecture code
**.ends

* expanding   symbol:  /home/wshh/Shiheng_Analog_Bootcamp/analog/schematics/opamp_single_stage.sym #
*+ of pins=5
** sym_path: /home/wshh/Shiheng_Analog_Bootcamp/analog/schematics/opamp_single_stage.sym
** sch_path: /home/wshh/Shiheng_Analog_Bootcamp/analog/schematics/opamp_single_stage.sch
.subckt opamp_single_stage VOUT VDD VIN_N VIN_P VSS
*.ipin VIN_P
*.ipin VIN_N
*.ipin VDD
*.ipin VSS
*.opin VOUT
XM1 net1 VIN_P net2 GND sky130_fd_pr__nfet_01v8 L=0.15 W=1 nf=1 + 1)/2) * @W / @nf * 0.29')
+ as=expr('int((@nf + 2)/2) * @W / @nf * 0.29') pd=expr('2*int((@nf + 1)/2) * (@W / @nf + 0.29)') ps=expr('2*int((@nf + 2)/2) * (@W / @nf + 0.29)')
+ nrd=expr('0.29 / @W ') nrs=expr('0.29 / @W ') sa=0 sb=0 sd=0 mult=1 m=1
XM9 VSS net3 net2 VDD sky130_fd_pr__pfet_01v8 L=0.15 W=1 nf=1 + 1)/2) * @W / @nf * 0.29')
+ as=expr('int((@nf + 2)/2) * @W / @nf * 0.29') pd=expr('2*int((@nf + 1)/2) * (@W / @nf + 0.29)') ps=expr('2*int((@nf + 2)/2) * (@W / @nf + 0.29)')
+ nrd=expr('0.29 / @W ') nrs=expr('0.29 / @W ') sa=0 sb=0 sd=0 mult=1 m=1
XM2 net2 VIN_N VOUT GND sky130_fd_pr__nfet_01v8 L=0.15 W=1 nf=1 + 1)/2) * @W / @nf * 0.29')
+ as=expr('int((@nf + 2)/2) * @W / @nf * 0.29') pd=expr('2*int((@nf + 1)/2) * (@W / @nf + 0.29)') ps=expr('2*int((@nf + 2)/2) * (@W / @nf + 0.29)')
+ nrd=expr('0.29 / @W ') nrs=expr('0.29 / @W ') sa=0 sb=0 sd=0 mult=1 m=1
XM3 VDD net1 net1 VDD sky130_fd_pr__pfet_01v8 L=0.15 W=1 nf=1 ad='int((nf+1)/2) * W/nf * 0.29' as='int((nf+2)/2) * W/nf * 0.29'
+ pd='2*int((nf+1)/2) * (W/nf + 0.29)' ps='2*int((nf+2)/2) * (W/nf + 0.29)' nrd='0.29 / W' nrs='0.29 / W'
+ sa=0 sb=0 sd=0 mult=1 m=1
XM4 VOUT net1 VDD VDD sky130_fd_pr__pfet_01v8 L=0.15 W=1 nf=1 ad='int((nf+1)/2) * W/nf * 0.29' as='int((nf+2)/2) * W/nf * 0.29'
+ pd='2*int((nf+1)/2) * (W/nf + 0.29)' ps='2*int((nf+2)/2) * (W/nf + 0.29)' nrd='0.29 / W' nrs='0.29 / W'
+ sa=0 sb=0 sd=0 mult=1 m=1
VB2 net3 net4 0.7
.ends

.GLOBAL GND
.end
